* Copyright 2020 The SkyWater PDK Authors
*
* Licensed under the Apache License, Version 2.0 (the "License");
* you may not use this file except in compliance with the License.
* You may obtain a copy of the License at
*
*     https://www.apache.org/licenses/LICENSE-2.0
*
* Unless required by applicable law or agreed to in writing, software
* distributed under the License is distributed on an "AS IS" BASIS,
* WITHOUT WARRANTIES OR CONDITIONS OF ANY KIND, either express or implied.
* See the License for the specific language governing permissions and
* limitations under the License.
*
* SPDX-License-Identifier: Apache-2.0

.subckt sky130_fd_bd_sram__openram_dp_cell BL0 BR0 BL1 BR1 WL0 WL1 VDD GND
X0 gnd gnd bl1 gnd sky130_fd_pr__special_nfet_latch w=0.21u l=80n
X1 a_38_133# wl0 a_38_133# vdd sky130_fd_pr__special_pfet_pass w=0.14u l=80n
X2 a_16_183# wl1 br1 gnd sky130_fd_pr__special_nfet_latch w=0.21u l=0.15u
X3 gnd gnd a_400_n79# gnd sky130_fd_pr__special_nfet_latch w=0.21u l=80n
X4 a_16_183# a_38_133# gnd gnd sky130_fd_pr__special_nfet_latch w=0.21u l=0.15u
X5 a_16_183# wl1 a_16_183# vdd sky130_fd_pr__special_pfet_pass w=0.14u l=80n
X6 a_38_133# wl1 bl1 gnd sky130_fd_pr__special_nfet_latch w=0.21u l=0.15u
X7 gnd gnd a_38_n79# gnd sky130_fd_pr__special_nfet_latch w=0.21u l=80n
X8 gnd gnd br1 gnd sky130_fd_pr__special_nfet_latch w=0.21u l=80n
X9 a_38_133# a_16_183# gnd gnd sky130_fd_pr__special_nfet_latch w=0.21u l=0.15u
X10 br0 wl0 a_16_183# gnd sky130_fd_pr__special_nfet_latch w=0.21u l=0.15u
X11 gnd a_38_133# a_16_183# gnd sky130_fd_pr__special_nfet_latch w=0.21u l=0.15u
X12 a_38_133# a_16_183# vdd vdd sky130_fd_pr__special_pfet_pass w=0.14u l=0.15u
X13 vdd a_38_133# a_16_183# vdd sky130_fd_pr__special_pfet_pass w=0.14u l=0.15u
X14 bl0 wl0 a_38_133# gnd sky130_fd_pr__special_nfet_latch w=0.21u l=0.15u
X15 gnd a_16_183# a_38_133# gnd sky130_fd_pr__special_nfet_latch w=0.21u l=0.15u
.ends
